`include "disciplines.vams"
`include "constants.vams"
`timescale 1ns/1ps

module k_nDAC_t2 (aout, clk, din);
  parameter integer resol = 8 from [1:64];
  input clk;
  logic clk;
  input [0:resol-1] din;
  logic din;
  output aout;
  wreal aout;

  parameter real fullscale = 1.0;
  parameter real id = 0 from [0:inf);
  parameter real td = 10n from [0:inf);
  parameter integer aedg = +1 from [-1:1] exclude 0;
  parameter integer dedg = (aedg == 1 ? 1 : 0);

  integer weight;
  real out, buffer;
  real sample[0:resol-1] = din[0:resol-1];
  integer i;

  always @(clk) begin
      if (clk == dedg) begin
          weight = 2;
          out = 0.0;
          for (i = resol-1; i >= 0; i = i-1) begin
              if (sample[i] == 1) begin
                  out = out + fullscale/weight;
              end
              weight = 2*weight;
          end
          buffer = #(td/ 1.0e-9) out;
      end
  end
  assign aout = buffer;
endmodule
