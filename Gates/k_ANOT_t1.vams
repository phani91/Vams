`include "disciplines.vams"
`include "constants.vams"

module k_ANOT_t1 (out, in);
    output out;
    input in;
    voltage out;
    voltage in;
    parameter real vh = 1;                // High level Voltage
    parameter real vl = 0;                // low level Voltage
    parameter real th = (vh+vl)/2;        // switching threshold
    parameter real id = 0 from [0:inf);   // inertial delay time
    parameter real td = 0 from [0:inf);   // transitional delay time

    analog begin
        @(cross(V(in)-th))
            ;
        V(out) <+ transition(!(V(in) > th) ? vh : vl, id, td);
    end
endmodule
