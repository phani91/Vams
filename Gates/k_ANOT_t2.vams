`include "disciplines.vams"
`include "constants.vams"

module k_ANOT_t2 (out, in);
    parameter size = 8;
    output [size-1:0] out;
    input [size-1:0] in;
    voltage [size-1:0] out;
    voltage [size-1:0] in;
    parameter real vh = 1;                // High level Voltage
    parameter real vl = 0;                // low level Voltage
    parameter real th = (vh+vl)/2;        // switching threshold
    parameter real id = 0 from [0:inf);   // inertial delay time
    parameter real td = 0 from [0:inf);   // transitional delay time
    genvar i;

    analog begin
        for(i=0; i<size; i++)
            @(cross(V(in[i])-th))
                ;
                V(out[i]) <+ transition(!((V(in1[i]) > th)) ? vh : vl, id, td);
    end
endmodule
