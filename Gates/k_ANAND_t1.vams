`include "disciplines.vams"
`include "constants.vams"

module k_ANAND_t1 (out, in);
    output out;
    input [1:0] in;
    voltage out;
    voltage [1:0] in;
    parameter real vh = 1;                // High level Voltage
    parameter real vl = 0;                // low level Voltage
    parameter real th = (vh+vl)/2;        // switching threshold
    parameter real id = 0 from [0:inf);   // inertial delay time
    parameter real td = 0 from [0:inf);   // transitional delay time

    analog begin
        @(cross(V(in[0])-th) or cross(V(in[1])-th))
            ;
        V(out) <+ transition(!((V(in[0]) > th) && (V(in[1]) > th)) ? vh : vl, id, td);
    end
endmodule
