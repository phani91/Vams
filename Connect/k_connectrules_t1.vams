`include "disciplines.vams"

connectrules Elec-Logic;
    connect k_Elec-Logic_t2;
endconnectrules
