`include "disciplines.vams"
`include "constants.vams"

module k_ffosc_t1 (out);
    output out;
    voltage out;

    parameter real freq = 1 from (0:inf);       // output signal frequency
    parameter real vh = +1;                     // input voltage in high state
    parameter real vl = -1;                     // input voltage in low state
    parameter real th = (vh+vl)/2;              // input threshold voltage
    parameter real id = 0 from [0:inf);         // Average delay input-output
    parameter real td = 0.01/freq from (0:inf); // transitional delay

    integer n;
    real next, incr;

    analog begin
        @(initial_step) begin
            incr = 0.5/freq;
            next = incr + $abstime;
        end

        @(timer(next)) begin
            n = !n;
            next = next + incr;
        end

        V(out) <+ transition( n ? vh : vl, id, td);
    end
endmodule
