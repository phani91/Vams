`include "disciplines.vams"
`include "constants.vams"

module k_Vfollower_t1 (p1, p2);
input p1;
output p2;
voltage p1, p2;

analog begin
    V(p2) <+ V(p1);
end
endmodule
