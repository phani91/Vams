`include "disciplines.vams"
`include "constants.vams"

module k_Vamplifier_t1 (p1, p2);
input p1;
output p2;
Voltage p1, p2;

parameter real gain = 5.0;

analog begin
    V(p2) <+ gain*V(p1);
end
endmodule
