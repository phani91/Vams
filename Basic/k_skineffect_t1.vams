`include "disciplines.vams"
`include "constants.vams"

module k_skineffect_t1 (p1, p2);
    electrical p1, p2;
//    inout p1, p2;
    branch (p1,p2) box;

    parameter real esr = 1 from (0:inf);        // External Series Resistance
    parameter real f0 = 1 from (0:inf);         // resonant frequency lower bound
    parameter real f1 = 10 from (f0:inf);       // resonant frequency upper bound
    parameter real fr = f1/f0;
    parameter integer lumps = 1.5*log(fr);      // Number of lumps

    real wp, wz;                                // pole and zero frequency coeff.
    real m;
    real zeroes[0:2*lumps-1], poles[0:2*lumps-1];
    genvar i;

    analog begin
        @(initial_step("static")) begin
            $strobe("lumps = %d, f0 = %f, f1 = %f, esr = %f\n", lumps, f0, f1, esr);
            m = pow(fr, 1.0/lumps);             // frequency span of each lump
            for (i = 0; i < 2*lumps; i = i+1) begin
                if (i%2 == 0) begin
                    zeroes[i] = -(f0*pow(m, (i - (3.0/4.0))));
                    poles[i] = -(f0*pow(m, (i-(1.0/4.0))));
                end else begin
                    zeroes[i] = 0;
                    poles[i] = 0;
                end
                $strobe("zero[%d] = %f, pole[%d] = %f\n", i, zeroes[i], i, poles[i]);
            end
        end
        V(box) <+ esr*laplace_zp( I(box), zeroes, poles);
    end
    endmodule
