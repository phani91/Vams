`include "disciplines.vams"
`include "constants.vams"

module k_series_rlc_t1(p1, p2);
electrical p1, p2;
parameter real r = 10e6;      // Resistance
parameter real c = 10e-12 exclude 0;    // Capacitance
parameter real l = 10e-9;     // Inductance

analog begin
    V(p1,p2) <+ r*I(p1,p2);
    V(p1,p2) <+ idt(I(p1,p2))/c;
    V(p1,p2) <+ l*idt(I(p1,p2));
end
endmodule
