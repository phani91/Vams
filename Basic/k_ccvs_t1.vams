`include "disciplines.vams"
`include "constants.vams"

module k_ccvs_t1 (pout, nout, pin. nin);
electrical pout, nout, pin. nin;
parameter real gain = 1;

analog I(pout,nout) <+ gain*V(pin.nin);
endmodule
