`include "disciplines.vams"
`include "constants.vams"

module k_shunt_rlc_t2 (p1, p2);
electrical p1, p2;
parameter real r = 10e6;      // Resistance
parameter real c = 10e-12;    // Capacitance
parameter real l = 10e-9;     // Inductance
branch (p1, p2) res, cap, ind;

analog begin
    V(res) <+ r*I(res);
    I(cap) <+ c*ddt(V(cap));
    V(ind) <+ l*ddt(I(ind));
end
endmodule
