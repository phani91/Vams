`include "disciplines.vams"
`include "constants.vams"

module k_Vsrc_t3 (p1,p2);
electrical p1, p2;
parameter real dc = 1.8;
parameter real mag = 1.8;           // AC stimulus magnitude
parameter real r = 1 from [0:inf);  // series resistance
branch (p1, p2) src;

analog begin
    V(src) <+ dc + ac_stim( "ac", mag ) + r*I(src);
end
endmodule
