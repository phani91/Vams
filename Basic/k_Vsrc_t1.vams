`include "disciplines.vams"
`include "constants.vams"

module k_Vsrc_t1 (p1, p2);
electrical p1, p2;
parameter real dc = 1.8;
branch (p1, p2) src;

analog begin
    V(src) <+ dc;
end
endmodule
