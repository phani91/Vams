`include "disciplines.vams"
`include "constants.vams"

module k_cap_t1 (p1, p2);
inout p1, p2;
electrical p1, p2;
parameter real c = 1 from [0:inf);
branch (p1, p2) cap;

analog begin
    I(cap) <+ c*ddt(V(cap));
end
endmodule
