`include "disciplines.vams"
`include "constants.vams"

module k_vccs_t1 (pout, nout, pin. nin);
electrical pout, nout, pin. nin;
parameter real gain = 1;

analog V(pout,nout) <+ gain*I(pin.nin);
endmodule
