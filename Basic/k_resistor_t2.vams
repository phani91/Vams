`include "disciplines.vams"
`include "constants.vams"

module k_resistor_t2 (p1, p2);
inout p1, p2;
electrical p1, p2;
parameter real r = 1;
branch (p1, p2) res;

analog begin
    if (r > 1e12*k_resistor_t2.flow.abstol)
        I(res) <+ V(res)/r;
    else
        V(res) <+ r*I(res);
end
endmodule
