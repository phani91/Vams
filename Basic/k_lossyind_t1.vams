`include "disciplines.vams"
`include "constants.vams"
/*`include "k_resistor_t2.vams"
`include "k_cap_t2.vams"
`inlcude "k_ind_t2.vams"
`include "k_skineffect_t1.vams"*/

module k_lossyind_t1 (p1, p2);
    electrical p1, p2;
    inout p1, p2;
    parameter real esr = 0.01 from (0:inf);             // External Series Resistance
    parameter real rp = 1.0 from (0:inf);               // Parallel resistance
    parameter real cp = 10f from (0:inf);               // parallel capacitance
    parameter real l = 1n from (0:inf);                 // inductance
    parameter real k = 1e-5 from (0:inf);               // k
    parameter real h = (1.0/(`M_SQRT2*k)) from (0:inf); // h
    electrical n1, n2;

    /*branch (p1, p2) box;
    branch (p1, n1) skin;
    branch (p1, n2) cap;
    branch (n1, p2) ind;
    branch (p2, n2) res;*/

    k_resistor_t2 #(.r(rp)) RP (p2, n2);
    k_skineffect_t1 #(.esr(esr), .f0(2*esr*esr*h*h),
                        .f1(1.0/(2*`M_PI*sqrt(l*cp)))) HR (p1, n1);
    k_cap_t2 #(.c(cp)) CP (p1, n2);
    k_ind_t2 #(.l(l)) L (n1, p2);
endmodule
