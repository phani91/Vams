`include "disciplines.vams"
`include "constants.vams"

module k_cccs_t1 (pout, nout, pin, nin);
input pin, nin;
output pout, nout;
electrical pout, nout, pin, nin;
branch (pout, nout) out;
branch (pin, nin) in;
parameter real gain = 1;

analog begin
	I(out) <+ gain*I(in);
endmodule
